* NGSPICE file created from AND_IC_TopLevel_parax.ext - technology: sky130A

.subckt AND_IC_TopLevel_parax A1 B1 Y1 A2 B2 Y2 GND A3 B3 Y3 VCC
X0 Y1.t1 a_1495_n929# VCC.t1 VCC.t0 sky130_fd_pr__pfet_01v8 ad=0.58 pd=4.58 as=0.58 ps=4.58 w=2 l=0.15
X1 a_14357_n3312# A2.t0 a_11087_n2558# GND.t14 sky130_fd_pr__nfet_01v8 ad=0.29 pd=2.58 as=0.29 ps=2.58 w=1 l=0.15
X2 a_2701_n1956# B1.t0 GND.t13 GND.t12 sky130_fd_pr__nfet_01v8 ad=0.29 pd=2.58 as=0.29 ps=2.58 w=1 l=0.15
X3 a_5139_n7948# A3.t1 a_6345_n6721# GND.t3 sky130_fd_pr__nfet_01v8 ad=0.29 pd=2.58 as=0.29 ps=2.58 w=1 l=0.15
X4 Y3.t0 a_5139_n7948# GND.t7 GND.t6 sky130_fd_pr__nfet_01v8 ad=0.29 pd=2.58 as=0.29 ps=2.58 w=1 l=0.15
X5 a_1495_n929# A1.t0 a_2701_n1956# GND.t2 sky130_fd_pr__nfet_01v8 ad=0.29 pd=2.58 as=0.29 ps=2.58 w=1 l=0.15
X6 GND.t9 B2.t0 a_14357_n3312# GND.t8 sky130_fd_pr__nfet_01v8 ad=0.29 pd=2.58 as=0.29 ps=2.58 w=1 l=0.15
X7 a_1495_n929# A1.t1 VCC.t3 VCC.t2 sky130_fd_pr__pfet_01v8 ad=0.58 pd=4.58 as=0.58 ps=4.58 w=2 l=0.15
X8 a_5139_n7948# A3.t0 VCC.t5 VCC.t4 sky130_fd_pr__pfet_01v8 ad=0.58 pd=4.58 as=0.58 ps=4.58 w=2 l=0.15
X9 VCC.t11 B2.t1 a_11087_n2558# VCC.t10 sky130_fd_pr__pfet_01v8 ad=0.58 pd=4.58 as=0.58 ps=4.58 w=2 l=0.15
X10 Y1.t0 a_1495_n929# GND.t1 GND.t0 sky130_fd_pr__nfet_01v8 ad=0.29 pd=2.58 as=0.29 ps=2.58 w=1 l=0.15
X11 a_6345_n6721# B3.t1 GND.t5 GND.t4 sky130_fd_pr__nfet_01v8 ad=0.29 pd=2.58 as=0.29 ps=2.58 w=1 l=0.15
X12 VCC.t17 A2.t1 a_11087_n2558# VCC.t16 sky130_fd_pr__pfet_01v8 ad=0.58 pd=4.58 as=0.58 ps=4.58 w=2 l=0.15
X13 GND.t11 a_11087_n2558# Y2.t0 GND.t10 sky130_fd_pr__nfet_01v8 ad=0.29 pd=2.58 as=0.29 ps=2.58 w=1 l=0.15
X14 VCC.t13 a_11087_n2558# Y2.t1 VCC.t12 sky130_fd_pr__pfet_01v8 ad=0.58 pd=4.58 as=0.58 ps=4.58 w=2 l=0.15
X15 Y3.t1 a_5139_n7948# VCC.t9 VCC.t8 sky130_fd_pr__pfet_01v8 ad=0.58 pd=4.58 as=0.58 ps=4.58 w=2 l=0.15
X16 a_1495_n929# B1.t1 VCC.t15 VCC.t14 sky130_fd_pr__pfet_01v8 ad=0.58 pd=4.58 as=0.58 ps=4.58 w=2 l=0.15
X17 a_5139_n7948# B3.t0 VCC.t7 VCC.t6 sky130_fd_pr__pfet_01v8 ad=0.58 pd=4.58 as=0.58 ps=4.58 w=2 l=0.15
R0 A3.n0 A3.t0 280.695
R1 A3.n0 A3.t1 192.986
R2 A3 A3.n0 1.14729
R3 Y3.n0 Y3.t1 115.704
R4 Y3.n0 Y3.t0 85.9182
R5 Y3.n1 Y3.n0 2.7055
R6 Y3.n1 Y3 0.3405
R7 Y3 Y3.n1 0.063625
R8 B3.n0 B3.t0 293.101
R9 B3.n0 B3.t1 197.582
R10 B3 B3.n2 5.7505
R11 B3 B3.n0 2.18143
R12 B3.n1 B3 0.33876
R13 B3.n2 B3.n1 0.130368
R14 B3.n1 B3 0.0597937
R15 B3.n2 B3 0.0018587
R16 A2.n0 A2.t1 280.707
R17 A2.n0 A2.t0 193.048
R18 A2.n1 A2 5.0005
R19 A2.n1 A2 5.0005
R20 A2 A2.n0 1.02229
R21 A2.n1 A2 0.129667
R22 A2 A2.n1 0.0255
R23 B2.n1 B2.t1 293.101
R24 B2.n1 B2.t0 197.582
R25 B2 B2.n1 2.05836
R26 B2.n0 B2 0.8505
R27 B2.n0 B2 0.104423
R28 B2 B2.n0 0.02175
R29 Y2.n0 Y2.t1 115.703
R30 Y2.n0 Y2.t0 85.9202
R31 Y2.n1 Y2.n0 2.7045
R32 Y2.n1 Y2 0.34425
R33 Y2 Y2.n1 0.06175
R34 Y1.n0 Y1.t1 115.703
R35 Y1.n0 Y1.t0 85.9192
R36 Y1.n1 Y1.n0 2.7055
R37 Y1.n1 Y1 0.34675
R38 Y1 Y1.n1 0.06175
R39 B1.n0 B1.t1 293.099
R40 B1.n0 B1.t0 197.579
R41 B1 B1.n0 2.18143
R42 A1.n0 A1.t1 280.707
R43 A1.n0 A1.t0 193.048
R44 A1.n1 A1 14.7505
R45 A1 A1.n0 1.14729
R46 A1.n1 A1 0.292872
R47 A1 A1.n1 0.07425
R48 A1.n1 A1 0.07425
R49 VCC.n5 VCC.n3 1789.41
R50 VCC.n8 VCC.n2 1789.41
R51 VCC.n16 VCC.n14 1789.41
R52 VCC.n19 VCC.n13 1789.41
R53 VCC.n27 VCC.n26 1789.41
R54 VCC.n29 VCC.n23 1789.41
R55 VCC.n101 VCC.n95 1789.41
R56 VCC.n99 VCC.n98 1789.41
R57 VCC.n91 VCC.n90 1789.41
R58 VCC.n88 VCC.n86 1789.41
R59 VCC.n80 VCC.n79 1789.41
R60 VCC.n77 VCC.n75 1789.41
R61 VCC.n69 VCC.n63 1789.41
R62 VCC.n67 VCC.n66 1789.41
R63 VCC.n58 VCC.n52 1789.41
R64 VCC.n56 VCC.n55 1789.41
R65 VCC.n47 VCC.n41 1789.41
R66 VCC.n45 VCC.n44 1789.41
R67 VCC.n4 VCC.n1 190.871
R68 VCC.n4 VCC.n0 190.871
R69 VCC.n15 VCC.n12 190.871
R70 VCC.n15 VCC.n11 190.871
R71 VCC.n30 VCC.n24 190.871
R72 VCC.n24 VCC.n22 190.871
R73 VCC.n102 VCC.n96 190.871
R74 VCC.n96 VCC.n94 190.871
R75 VCC.n87 VCC.n84 190.871
R76 VCC.n87 VCC.n83 190.871
R77 VCC.n76 VCC.n73 190.871
R78 VCC.n76 VCC.n72 190.871
R79 VCC.n70 VCC.n62 190.871
R80 VCC.n64 VCC.n62 190.871
R81 VCC.n59 VCC.n51 190.871
R82 VCC.n53 VCC.n51 190.871
R83 VCC.n48 VCC.n40 190.871
R84 VCC.n42 VCC.n40 190.871
R85 VCC.n9 VCC.n1 185.077
R86 VCC.n81 VCC.n73 185.077
R87 VCC.n64 VCC.n61 185.077
R88 VCC.n31 VCC.n30 184.889
R89 VCC.n103 VCC.n102 184.889
R90 VCC.n42 VCC.n39 184.889
R91 VCC.n53 VCC.n50 184.881
R92 VCC.n20 VCC.n12 184.881
R93 VCC.n92 VCC.n84 184.881
R94 VCC.n31 VCC.n22 184.798
R95 VCC.n103 VCC.n94 184.798
R96 VCC.n49 VCC.n48 184.512
R97 VCC.n21 VCC.n11 184.308
R98 VCC.n93 VCC.n83 184.308
R99 VCC.n60 VCC.n59 184.03
R100 VCC.n10 VCC.n0 183.554
R101 VCC.n82 VCC.n72 183.554
R102 VCC.n71 VCC.n70 183.276
R103 VCC.n6 VCC.n2 173.642
R104 VCC.n7 VCC.n3 173.642
R105 VCC.n17 VCC.n13 173.642
R106 VCC.n18 VCC.n14 173.642
R107 VCC.n29 VCC.n28 173.642
R108 VCC.n26 VCC.n25 173.642
R109 VCC.n98 VCC.n97 173.642
R110 VCC.n101 VCC.n100 173.642
R111 VCC.n86 VCC.n85 173.642
R112 VCC.n90 VCC.n89 173.642
R113 VCC.n75 VCC.n74 173.642
R114 VCC.n79 VCC.n78 173.642
R115 VCC.n66 VCC.n65 173.642
R116 VCC.n69 VCC.n68 173.642
R117 VCC.n55 VCC.n54 173.642
R118 VCC.n58 VCC.n57 173.642
R119 VCC.n44 VCC.n43 173.642
R120 VCC.n47 VCC.n46 173.642
R121 VCC.n32 VCC.t5 114.481
R122 VCC.n104 VCC.t3 114.481
R123 VCC.n115 VCC.t17 114.481
R124 VCC.n36 VCC.t9 114.407
R125 VCC.n108 VCC.t1 114.407
R126 VCC.n111 VCC.t13 114.407
R127 VCC.n34 VCC.t7 114.391
R128 VCC.n106 VCC.t15 114.391
R129 VCC.n113 VCC.t11 114.391
R130 VCC.n5 VCC.n4 92.5005
R131 VCC.n9 VCC.n8 92.5005
R132 VCC.n16 VCC.n15 92.5005
R133 VCC.n20 VCC.n19 92.5005
R134 VCC.n27 VCC.n24 92.5005
R135 VCC.n31 VCC.n23 92.5005
R136 VCC.n99 VCC.n96 92.5005
R137 VCC.n103 VCC.n95 92.5005
R138 VCC.n88 VCC.n87 92.5005
R139 VCC.n92 VCC.n91 92.5005
R140 VCC.n77 VCC.n76 92.5005
R141 VCC.n81 VCC.n80 92.5005
R142 VCC.n67 VCC.n62 92.5005
R143 VCC.n63 VCC.n61 92.5005
R144 VCC.n56 VCC.n51 92.5005
R145 VCC.n52 VCC.n50 92.5005
R146 VCC.n45 VCC.n40 92.5005
R147 VCC.n41 VCC.n39 92.5005
R148 VCC.n6 VCC.n5 79.4196
R149 VCC.n8 VCC.n7 79.4196
R150 VCC.n17 VCC.n16 79.4196
R151 VCC.n19 VCC.n18 79.4196
R152 VCC.n28 VCC.n27 79.4196
R153 VCC.n25 VCC.n23 79.4196
R154 VCC.n97 VCC.n95 79.4196
R155 VCC.n100 VCC.n99 79.4196
R156 VCC.n91 VCC.n85 79.4196
R157 VCC.n89 VCC.n88 79.4196
R158 VCC.n80 VCC.n74 79.4196
R159 VCC.n78 VCC.n77 79.4196
R160 VCC.n65 VCC.n63 79.4196
R161 VCC.n68 VCC.n67 79.4196
R162 VCC.n54 VCC.n52 79.4196
R163 VCC.n57 VCC.n56 79.4196
R164 VCC.n43 VCC.n41 79.4196
R165 VCC.n46 VCC.n45 79.4196
R166 VCC.n2 VCC.n1 23.1255
R167 VCC.n3 VCC.n0 23.1255
R168 VCC.n13 VCC.n12 23.1255
R169 VCC.n14 VCC.n11 23.1255
R170 VCC.n30 VCC.n29 23.1255
R171 VCC.n26 VCC.n22 23.1255
R172 VCC.n102 VCC.n101 23.1255
R173 VCC.n98 VCC.n94 23.1255
R174 VCC.n90 VCC.n84 23.1255
R175 VCC.n86 VCC.n83 23.1255
R176 VCC.n79 VCC.n73 23.1255
R177 VCC.n75 VCC.n72 23.1255
R178 VCC.n70 VCC.n69 23.1255
R179 VCC.n66 VCC.n64 23.1255
R180 VCC.n59 VCC.n58 23.1255
R181 VCC.n55 VCC.n53 23.1255
R182 VCC.n48 VCC.n47 23.1255
R183 VCC.n44 VCC.n42 23.1255
R184 VCC.n38 VCC.n37 9.06686
R185 VCC.n7 VCC.t8 8.97701
R186 VCC.t8 VCC.n6 8.97701
R187 VCC.n18 VCC.t6 8.97701
R188 VCC.t6 VCC.n17 8.97701
R189 VCC.n25 VCC.t4 8.97701
R190 VCC.n28 VCC.t4 8.97701
R191 VCC.n100 VCC.t2 8.97701
R192 VCC.n97 VCC.t2 8.97701
R193 VCC.n89 VCC.t14 8.97701
R194 VCC.t14 VCC.n85 8.97701
R195 VCC.n78 VCC.t0 8.97701
R196 VCC.t0 VCC.n74 8.97701
R197 VCC.n68 VCC.t12 8.97701
R198 VCC.n65 VCC.t12 8.97701
R199 VCC.n57 VCC.t10 8.97701
R200 VCC.n54 VCC.t10 8.97701
R201 VCC.n46 VCC.t16 8.97701
R202 VCC.n43 VCC.t16 8.97701
R203 VCC.n105 VCC.n103 4.98617
R204 VCC.n114 VCC.n49 4.98617
R205 VCC.n33 VCC.n31 4.98547
R206 VCC.n35 VCC.n21 4.97495
R207 VCC.n107 VCC.n93 4.97495
R208 VCC.n112 VCC.n60 4.97495
R209 VCC.n37 VCC.n10 4.97319
R210 VCC.n109 VCC.n82 4.97319
R211 VCC.n110 VCC.n71 4.97319
R212 VCC.n110 VCC.n109 2.58904
R213 VCC.n71 VCC.n61 1.11354
R214 VCC.n36 VCC.n35 0.985582
R215 VCC.n108 VCC.n107 0.985582
R216 VCC.n112 VCC.n111 0.985582
R217 VCC.n34 VCC.n33 0.963463
R218 VCC.n106 VCC.n105 0.963463
R219 VCC.n114 VCC.n113 0.963463
R220 VCC VCC.n38 0.894019
R221 VCC.n10 VCC.n9 0.835283
R222 VCC.n82 VCC.n81 0.835283
R223 VCC.n60 VCC.n50 0.557022
R224 VCC.n32 VCC 0.496385
R225 VCC.n104 VCC 0.496385
R226 VCC VCC.n115 0.393504
R227 VCC.n49 VCC.n39 0.284944
R228 VCC.n21 VCC.n20 0.278761
R229 VCC.n93 VCC.n92 0.278761
R230 VCC.n33 VCC.n32 0.218607
R231 VCC.n105 VCC.n104 0.218607
R232 VCC.n115 VCC.n114 0.218607
R233 VCC.n37 VCC.n36 0.215006
R234 VCC.n109 VCC.n108 0.215006
R235 VCC.n111 VCC.n110 0.214492
R236 VCC.n113 VCC.n112 0.203175
R237 VCC.n35 VCC.n34 0.20266
R238 VCC.n107 VCC.n106 0.20266
R239 VCC.n38 VCC 0.0549181
R240 GND.n81 GND.n61 15334.9
R241 GND.n65 GND.n62 7269.2
R242 GND.n20 GND.n7 6822.52
R243 GND.n47 GND.n7 6364.23
R244 GND.n80 GND.n67 6136.96
R245 GND.n112 GND.n47 5582.07
R246 GND.n62 GND.n48 5565.76
R247 GND.n30 GND.n24 2306.06
R248 GND.n30 GND.n26 2306.06
R249 GND.n24 GND.n23 2306.06
R250 GND.n26 GND.n23 2306.06
R251 GND.n12 GND.n8 2306.06
R252 GND.n42 GND.n8 2306.06
R253 GND.n12 GND.n9 2306.06
R254 GND.n42 GND.n9 2306.06
R255 GND.n32 GND.n18 2306.06
R256 GND.n32 GND.n19 2306.06
R257 GND.n33 GND.n18 2306.06
R258 GND.n33 GND.n19 2306.06
R259 GND.n74 GND.n68 2306.06
R260 GND.n78 GND.n68 2306.06
R261 GND.n74 GND.n69 2306.06
R262 GND.n78 GND.n69 2306.06
R263 GND.n93 GND.n52 2306.06
R264 GND.n63 GND.n52 2306.06
R265 GND.n93 GND.n53 2306.06
R266 GND.n63 GND.n53 2306.06
R267 GND.n98 GND.n95 2306.06
R268 GND.n102 GND.n95 2306.06
R269 GND.n98 GND.n96 2306.06
R270 GND.n102 GND.n96 2306.06
R271 GND.n109 GND.n50 2306.06
R272 GND.n105 GND.n50 2306.06
R273 GND.n109 GND.n51 2306.06
R274 GND.n105 GND.n51 2306.06
R275 GND.n71 GND.n59 2306.06
R276 GND.n82 GND.n59 2306.06
R277 GND.n71 GND.n60 2306.06
R278 GND.n82 GND.n60 2306.06
R279 GND.n45 GND.n5 2306.06
R280 GND.n114 GND.n5 2306.06
R281 GND.n45 GND.n6 2306.06
R282 GND.n114 GND.n6 2306.06
R283 GND.n111 GND.n48 2289.56
R284 GND.n67 GND.n62 1745.83
R285 GND.n25 GND.n7 1130.32
R286 GND.n66 GND.n61 801.064
R287 GND.n112 GND.n111 625.86
R288 GND.n11 GND.n7 575.456
R289 GND.n47 GND.n43 573.107
R290 GND.n66 GND.n65 562.087
R291 GND.n113 GND.n112 558.607
R292 GND.n111 GND.n110 388.534
R293 GND.n91 GND.n53 292.5
R294 GND.n53 GND.t0 292.5
R295 GND.n54 GND.n52 292.5
R296 GND.n52 GND.t0 292.5
R297 GND.n69 GND.n56 292.5
R298 GND.t2 GND.n69 292.5
R299 GND.n76 GND.n68 292.5
R300 GND.t2 GND.n68 292.5
R301 GND.n59 GND.n58 292.5
R302 GND.t12 GND.n59 292.5
R303 GND.n60 GND.n57 292.5
R304 GND.t12 GND.n60 292.5
R305 GND.n34 GND.n33 292.5
R306 GND.n33 GND.t8 292.5
R307 GND.n32 GND.n31 292.5
R308 GND.t8 GND.n32 292.5
R309 GND.n40 GND.n9 292.5
R310 GND.n9 GND.t10 292.5
R311 GND.n10 GND.n8 292.5
R312 GND.n8 GND.t10 292.5
R313 GND.n23 GND.n14 292.5
R314 GND.t14 GND.n23 292.5
R315 GND.n30 GND.n29 292.5
R316 GND.t14 GND.n30 292.5
R317 GND.n107 GND.n51 292.5
R318 GND.t3 GND.n51 292.5
R319 GND.n50 GND.n1 292.5
R320 GND.t3 GND.n50 292.5
R321 GND.n100 GND.n96 292.5
R322 GND.n96 GND.t4 292.5
R323 GND.n97 GND.n95 292.5
R324 GND.t4 GND.n95 292.5
R325 GND.n6 GND.n4 292.5
R326 GND.t6 GND.n6 292.5
R327 GND.n5 GND.n3 292.5
R328 GND.t6 GND.n5 292.5
R329 GND.n73 GND.n61 263.303
R330 GND.n65 GND.n64 180.853
R331 GND.n76 GND.n75 149.835
R332 GND.n77 GND.n76 149.835
R333 GND.n92 GND.n54 149.835
R334 GND.n55 GND.n54 149.835
R335 GND.n100 GND.n99 149.835
R336 GND.n101 GND.n100 149.835
R337 GND.n108 GND.n107 149.835
R338 GND.n107 GND.n106 149.835
R339 GND.n83 GND.n58 149.835
R340 GND.n70 GND.n58 149.835
R341 GND.n29 GND.n28 149.835
R342 GND.n29 GND.n27 149.835
R343 GND.n41 GND.n10 149.835
R344 GND.n13 GND.n10 149.835
R345 GND.n31 GND.n16 149.835
R346 GND.n31 GND.n17 149.835
R347 GND.n115 GND.n4 149.835
R348 GND.n44 GND.n4 149.835
R349 GND.n99 GND.n97 142.805
R350 GND.n70 GND.n57 142.805
R351 GND.n34 GND.n17 142.805
R352 GND.n75 GND.n56 142.728
R353 GND.n77 GND.n56 142.728
R354 GND.n106 GND.n1 142.728
R355 GND.n108 GND.n1 142.728
R356 GND.n28 GND.n14 142.728
R357 GND.n27 GND.n14 142.728
R358 GND.n34 GND.n16 142.69
R359 GND.n101 GND.n0 142.429
R360 GND.n84 GND.n83 142.429
R361 GND.n92 GND.n91 142.306
R362 GND.n41 GND.n40 142.306
R363 GND.n44 GND.n3 142.306
R364 GND.n90 GND.n55 140.758
R365 GND.n116 GND.n115 140.758
R366 GND.n39 GND.n13 140.758
R367 GND.n20 GND.n18 121.576
R368 GND.n82 GND.n81 117.212
R369 GND.n106 GND.n105 117.001
R370 GND.n105 GND.n104 117.001
R371 GND.n102 GND.n101 117.001
R372 GND.n103 GND.n102 117.001
R373 GND.n63 GND.n55 117.001
R374 GND.n64 GND.n63 117.001
R375 GND.n93 GND.n92 117.001
R376 GND.n94 GND.n93 117.001
R377 GND.n78 GND.n77 117.001
R378 GND.n79 GND.n78 117.001
R379 GND.n75 GND.n74 117.001
R380 GND.n74 GND.n73 117.001
R381 GND.n83 GND.n82 117.001
R382 GND.n71 GND.n70 117.001
R383 GND.n72 GND.n71 117.001
R384 GND.n19 GND.n17 117.001
R385 GND.n22 GND.n19 117.001
R386 GND.n18 GND.n16 117.001
R387 GND.n42 GND.n41 117.001
R388 GND.n43 GND.n42 117.001
R389 GND.n13 GND.n12 117.001
R390 GND.n12 GND.n11 117.001
R391 GND.n28 GND.n26 117.001
R392 GND.n26 GND.n25 117.001
R393 GND.n27 GND.n24 117.001
R394 GND.n24 GND.n21 117.001
R395 GND.n109 GND.n108 117.001
R396 GND.n110 GND.n109 117.001
R397 GND.n99 GND.n98 117.001
R398 GND.n98 GND.n49 117.001
R399 GND.n115 GND.n114 117.001
R400 GND.n114 GND.n113 117.001
R401 GND.n45 GND.n44 117.001
R402 GND.n46 GND.n45 117.001
R403 GND.n72 GND.t2 103.898
R404 GND.n79 GND.t12 103.898
R405 GND.n121 GND.t5 90.9557
R406 GND.n15 GND.t9 90.9557
R407 GND.n85 GND.t13 90.955
R408 GND.n94 GND.t0 90.4271
R409 GND.n64 GND.t0 90.4271
R410 GND.n11 GND.t10 90.3801
R411 GND.n43 GND.t10 90.3801
R412 GND.n46 GND.t6 87.734
R413 GND.n113 GND.t6 87.734
R414 GND.n117 GND.t7 85.4529
R415 GND.n88 GND.t1 85.4529
R416 GND.n37 GND.t11 85.4519
R417 GND.t8 GND.n21 83.5158
R418 GND.t14 GND.n22 83.5158
R419 GND.t3 GND.n49 81.0707
R420 GND.t4 GND.n48 68.2993
R421 GND.n67 GND.n66 52.4905
R422 GND.n47 GND.n46 29.4301
R423 GND.n87 GND.n56 20.6384
R424 GND.n36 GND.n14 20.6384
R425 GND.n119 GND.n1 20.6377
R426 GND.n104 GND.n48 13.1639
R427 GND.n103 GND.n94 10.3023
R428 GND.n73 GND.n72 8.54004
R429 GND.t2 GND.t12 8.54004
R430 GND.n104 GND.n103 6.86835
R431 GND.t8 GND.t14 6.86477
R432 GND.n25 GND.n22 6.86477
R433 GND.n110 GND.n49 6.6638
R434 GND.t4 GND.t3 6.6638
R435 GND.n117 GND.n116 5.60386
R436 GND.n81 GND.n80 5.48147
R437 GND.n90 GND.n89 5.39378
R438 GND.n39 GND.n38 5.39378
R439 GND.n120 GND.n0 4.82859
R440 GND.n86 GND.n84 4.82792
R441 GND.n35 GND.n34 4.82792
R442 GND.n80 GND.n79 2.84701
R443 GND.n21 GND.n20 2.28859
R444 GND.n38 GND.n2 1.36379
R445 GND.n89 GND.n2 1.04233
R446 GND.n85 GND 0.984816
R447 GND GND.n121 0.984816
R448 GND.n88 GND.n87 0.916375
R449 GND.n37 GND.n36 0.916375
R450 GND.n15 GND 0.889759
R451 GND.n91 GND.n90 0.711611
R452 GND.n40 GND.n39 0.711611
R453 GND.n116 GND.n3 0.711611
R454 GND.n118 GND.n117 0.480538
R455 GND.n36 GND.n35 0.442515
R456 GND.n87 GND.n86 0.44204
R457 GND.n120 GND.n119 0.44204
R458 GND.n119 GND 0.395937
R459 GND.n86 GND.n85 0.284721
R460 GND.n35 GND.n15 0.284721
R461 GND.n121 GND.n120 0.284721
R462 GND.n97 GND.n0 0.261724
R463 GND.n84 GND.n57 0.261724
R464 GND.n118 GND.n2 0.227211
R465 GND.n89 GND.n88 0.210576
R466 GND.n38 GND.n37 0.210101
R467 GND GND.n118 0.0408992
C0 a_5139_n7948# a_6345_n6721# 0.29173f
C1 VCC B1 0.55508f
C2 B3 a_6345_n6721# 0.35342f
C3 B1 a_1495_n929# 0.29143f
C4 B3 a_5139_n7948# 0.29143f
C5 a_2701_n1956# a_1495_n929# 0.29173f
C6 Y1 Y2 0.04309f
C7 VCC Y1 0.67147f
C8 a_5139_n7948# VCC 2.79991f
C9 A1 B1 0.08835f
C10 B2 a_11087_n2558# 0.29143f
C11 VCC B2 0.56146f
C12 Y1 a_1495_n929# 1.04713f
C13 a_5139_n7948# Y3 1.04686f
C14 B3 VCC 0.55508f
C15 A1 a_2701_n1956# 0.40224f
C16 Y2 a_11087_n2558# 1.04697f
C17 VCC Y2 0.67149f
C18 B2 A2 0.09162f
C19 VCC a_11087_n2558# 2.79991f
C20 a_6345_n6721# A3 0.40224f
C21 a_14357_n3312# B2 0.35342f
C22 VCC a_1495_n929# 2.79991f
C23 Y3 VCC 0.66762f
C24 A2 a_11087_n2558# 0.42541f
C25 VCC A2 0.57904f
C26 B1 a_2701_n1956# 0.35342f
C27 a_5139_n7948# A3 0.42541f
C28 a_14357_n3312# a_11087_n2558# 0.29173f
C29 B3 A3 0.0907f
C30 A1 VCC 0.57277f
C31 a_14357_n3312# A2 0.40224f
C32 A1 a_1495_n929# 0.42541f
C33 VCC A3 0.57277f
C34 A3 GND 2.81967f
C35 Y3 GND 2.51264f
C36 B3 GND 4.51805f
C37 A2 GND 2.77619f
C38 B2 GND 4.64322f
C39 Y2 GND 2.4721f
C40 Y1 GND 2.47477f
C41 B1 GND 4.62965f
C42 A1 GND 2.55587f
C43 VCC GND 41.7587f
C44 a_5139_n7948# GND 5.26947f
C45 a_6345_n6721# GND 1.4791f
C46 a_14357_n3312# GND 1.4791f
C47 a_2701_n1956# GND 1.4791f
C48 a_11087_n2558# GND 5.26934f
C49 a_1495_n929# GND 5.26916f
C50 VCC.n0 GND 0.01331f
C51 VCC.n1 GND 0.01336f
C52 VCC.n2 GND 0.08882f
C53 VCC.n3 GND 0.08882f
C54 VCC.n4 GND 0.01386f
C55 VCC.n5 GND 0.01386f
C56 VCC.t8 GND 0.12121f
C57 VCC.n8 GND 0.01386f
C58 VCC.n9 GND 0.0077f
C59 VCC.n10 GND 0.01023f
C60 VCC.t9 GND 0.01698f
C61 VCC.n11 GND 0.01333f
C62 VCC.n12 GND 0.01335f
C63 VCC.n13 GND 0.08882f
C64 VCC.n14 GND 0.08882f
C65 VCC.n15 GND 0.01386f
C66 VCC.n16 GND 0.01386f
C67 VCC.t6 GND 0.12121f
C68 VCC.n19 GND 0.01386f
C69 VCC.n20 GND 0.00768f
C70 VCC.n21 GND 0.01014f
C71 VCC.t7 GND 0.01694f
C72 VCC.n22 GND 0.01335f
C73 VCC.n23 GND 0.01386f
C74 VCC.n24 GND 0.01386f
C75 VCC.t4 GND 0.12121f
C76 VCC.n26 GND 0.08882f
C77 VCC.n27 GND 0.01386f
C78 VCC.n29 GND 0.08882f
C79 VCC.n30 GND 0.01336f
C80 VCC.n31 GND 0.01779f
C81 VCC.t5 GND 0.01698f
C82 VCC.n32 GND 0.29671f
C83 VCC.n33 GND 0.28155f
C84 VCC.n34 GND 0.38767f
C85 VCC.n35 GND 0.28397f
C86 VCC.n36 GND 0.39984f
C87 VCC.n37 GND 1.76608f
C88 VCC.n38 GND 1.87314f
C89 VCC.t17 GND 0.01698f
C90 VCC.n39 GND 0.00767f
C91 VCC.n40 GND 0.01386f
C92 VCC.n41 GND 0.01386f
C93 VCC.t16 GND 0.12121f
C94 VCC.n42 GND 0.01336f
C95 VCC.n44 GND 0.08882f
C96 VCC.n45 GND 0.01386f
C97 VCC.n47 GND 0.08882f
C98 VCC.n48 GND 0.01334f
C99 VCC.n49 GND 0.01014f
C100 VCC.t11 GND 0.01694f
C101 VCC.n50 GND 0.0077f
C102 VCC.n51 GND 0.01386f
C103 VCC.n52 GND 0.01386f
C104 VCC.t10 GND 0.12121f
C105 VCC.n53 GND 0.01335f
C106 VCC.n55 GND 0.08882f
C107 VCC.n56 GND 0.01386f
C108 VCC.n58 GND 0.08882f
C109 VCC.n59 GND 0.01332f
C110 VCC.n60 GND 0.01013f
C111 VCC.t13 GND 0.01698f
C112 VCC.n61 GND 0.00771f
C113 VCC.n62 GND 0.01386f
C114 VCC.n63 GND 0.01386f
C115 VCC.t12 GND 0.12121f
C116 VCC.n64 GND 0.01336f
C117 VCC.n66 GND 0.08882f
C118 VCC.n67 GND 0.01386f
C119 VCC.n69 GND 0.08882f
C120 VCC.n70 GND 0.0133f
C121 VCC.n71 GND 0.01023f
C122 VCC.n72 GND 0.01331f
C123 VCC.n73 GND 0.01336f
C124 VCC.t0 GND 0.12121f
C125 VCC.n75 GND 0.08882f
C126 VCC.n76 GND 0.01386f
C127 VCC.n77 GND 0.01386f
C128 VCC.n79 GND 0.08882f
C129 VCC.n80 GND 0.01386f
C130 VCC.n81 GND 0.0077f
C131 VCC.n82 GND 0.01023f
C132 VCC.t1 GND 0.01698f
C133 VCC.n83 GND 0.01333f
C134 VCC.n84 GND 0.01335f
C135 VCC.t14 GND 0.12121f
C136 VCC.n86 GND 0.08882f
C137 VCC.n87 GND 0.01386f
C138 VCC.n88 GND 0.01386f
C139 VCC.n90 GND 0.08882f
C140 VCC.n91 GND 0.01386f
C141 VCC.n92 GND 0.00768f
C142 VCC.n93 GND 0.01014f
C143 VCC.t15 GND 0.01694f
C144 VCC.n94 GND 0.01335f
C145 VCC.n95 GND 0.01386f
C146 VCC.n96 GND 0.01386f
C147 VCC.t2 GND 0.12121f
C148 VCC.n98 GND 0.08882f
C149 VCC.n99 GND 0.01386f
C150 VCC.n101 GND 0.08882f
C151 VCC.n102 GND 0.01336f
C152 VCC.n103 GND 0.01779f
C153 VCC.t3 GND 0.01698f
C154 VCC.n104 GND 0.29671f
C155 VCC.n105 GND 0.28155f
C156 VCC.n106 GND 0.38767f
C157 VCC.n107 GND 0.28397f
C158 VCC.n108 GND 0.39984f
C159 VCC.n109 GND 0.57967f
C160 VCC.n110 GND 0.58018f
C161 VCC.n111 GND 0.39974f
C162 VCC.n112 GND 0.28406f
C163 VCC.n113 GND 0.38776f
C164 VCC.n114 GND 0.28155f
C165 VCC.n115 GND 0.27803f
C166 A1.t1 GND 0.03983f
C167 A1.t0 GND 0.03218f
C168 A1.n0 GND 0.78933f
C169 A1.n1 GND 0.22316f
C170 B1.t1 GND 0.03657f
C171 B1.t0 GND 0.02163f
C172 B1.n0 GND 0.7177f
C173 Y1.t1 GND 0.05311f
C174 Y1.t0 GND 0.02784f
C175 Y1.n0 GND 1.05108f
C176 Y1.n1 GND 0.38546f
C177 Y2.t1 GND 0.05316f
C178 Y2.t0 GND 0.02787f
C179 Y2.n0 GND 1.05218f
C180 Y2.n1 GND 0.38482f
C181 B2.n0 GND 0.04587f
C182 B2.t1 GND 0.03616f
C183 B2.t0 GND 0.02139f
C184 B2.n1 GND 0.69366f
C185 A2.t1 GND 0.03896f
C186 A2.t0 GND 0.03148f
C187 A2.n0 GND 0.74896f
C188 A2.n1 GND 0.07977f
C189 B3.t1 GND 0.02139f
C190 B3.t0 GND 0.03617f
C191 B3.n0 GND 0.70972f
C192 B3.n1 GND 0.13576f
C193 B3.n2 GND 0.00849f
C194 Y3.t0 GND 0.02719f
C195 Y3.t1 GND 0.05187f
C196 Y3.n0 GND 1.02659f
C197 Y3.n1 GND 0.37489f
C198 A3.t1 GND 0.0315f
C199 A3.t0 GND 0.03909f
C200 A3.n0 GND 0.77501f
.ends
