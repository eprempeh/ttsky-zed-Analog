** sch_path: /home/eprempeh/ttsky-zed-Analog/xschem/AND_IC_TopLevel.sch
.subckt AND_IC_TopLevel A1 B1 Y1 A2 B2 Y2 GND A3 B3 Y3 VCC
*.PININFO A1:I GND:B Y1:O B1:I A2:I B2:I A3:I Y2:O Y3:O VCC:B B3:I
x1 A1 B1 Y1 VCC GND ic_7804_AND
x2 A2 B2 Y2 VCC GND ic_7804_AND
x3 A3 B3 Y3 VCC GND ic_7804_AND
.ends

* expanding   symbol:  ic_7804_AND.sym # of pins=5
** sym_path: /home/eprempeh/ttsky-zed-Analog/xschem/ic_7804_AND.sym
** sch_path: /home/eprempeh/ttsky-zed-Analog/xschem/ic_7804_AND.sch
.subckt ic_7804_AND A B Y VCC GND
*.PININFO A:I Y:O B:I VCC:B GND:B
XM2 net1 A VCC VCC sky130_fd_pr__pfet_01v8 L=0.15 W=2 nf=1
XM3 net1 B VCC VCC sky130_fd_pr__pfet_01v8 L=0.15 W=2 nf=1
XM5 Y net1 VCC VCC sky130_fd_pr__pfet_01v8 L=0.15 W=2 nf=1
XM1 net1 A net2 GND sky130_fd_pr__nfet_01v8 L=0.15 W=1 nf=1
XM4 net2 B GND GND sky130_fd_pr__nfet_01v8 L=0.15 W=1 nf=1
XM6 Y net1 GND GND sky130_fd_pr__nfet_01v8 L=0.15 W=1 nf=1
.ends
