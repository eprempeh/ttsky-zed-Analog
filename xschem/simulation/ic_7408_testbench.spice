** sch_path: /home/eprempeh/ttsky-zed-Analog/xschem/ic_7408_testbench.sch
**.subckt ic_7408_testbench A1 GND Y1 B1 A2 B2 A3 Y2 Y3 VCC B3
*.ipin A1
*.iopin GND
*.opin Y1
*.ipin B1
*.ipin A2
*.ipin B2
*.ipin A3
*.opin Y2
*.opin Y3
*.iopin VCC
*.ipin B3
V1 VCC GND 1.8
V2 A1 GND pulse(0 1.8 1u 1n 1n 2u 4u)
V3 B1 GND pulse(0 1.8 1u 1n 1n 2u 4u)
R1 out_1y_before Y1 1k
C1 Y1 GND 10p
Vmeas VCC net1 0
.save i(vmeas)
V4 A2 GND 1.8
V5 B2 GND 1.8
V6 B3 GND 1.8
V7 A3 GND 1.8
x1 A1 B1 out_1y_before A2 B2 Y2 GND A3 B3 Y3 net1 AND_IC_TopLevel
R2 out_1y_before1 Y1_parax 1k
C2 Y1_parax GND 10p
Vmeas1 VCC net2 0
.save i(vmeas1)
x2 A1 B1 out_1y_before1 A2 B2 Y2 GND A3 B3 Y3 net2 AND_IC_TopLevel_parax
**** begin user architecture code

** opencircuitdesign pdks install
.lib /home/eprempeh/pdk/sky130A/libs.tech/ngspice/sky130.lib.spice tt

.tran 10n 8u
.save all

.control

run
write final_testbench.raw

.endc

**** end user architecture code
**.ends

* expanding   symbol:  AND_IC_TopLevel.sym # of pins=11
** sym_path: /home/eprempeh/ttsky-zed-Analog/xschem/AND_IC_TopLevel.sym
** sch_path: /home/eprempeh/ttsky-zed-Analog/xschem/AND_IC_TopLevel.sch
.subckt AND_IC_TopLevel A1 B1 Y1 A2 B2 Y2 GND A3 B3 Y3 VCC
*.ipin A1
*.iopin GND
*.opin Y1
*.ipin B1
*.ipin A2
*.ipin B2
*.ipin A3
*.opin Y2
*.opin Y3
*.iopin VCC
*.ipin B3
x1 A1 B1 Y1 VCC GND ic_7804_AND
x2 A2 B2 Y2 VCC GND ic_7804_AND
x3 A3 B3 Y3 VCC GND ic_7804_AND
.ends

* expanding   symbol:  AND_IC_TopLevel_parax.sym # of pins=11
** sym_path: /home/eprempeh/ttsky-zed-Analog/xschem/AND_IC_TopLevel.sym
.include /home/eprempeh/ttsky-zed-Analog/mag/AND_IC_TopLevel.sim.spice

* expanding   symbol:  ic_7804_AND.sym # of pins=5
** sym_path: /home/eprempeh/ttsky-zed-Analog/xschem/ic_7804_AND.sym
** sch_path: /home/eprempeh/ttsky-zed-Analog/xschem/ic_7804_AND.sch
.subckt ic_7804_AND A B Y VCC GND
*.ipin A
*.opin Y
*.ipin B
*.iopin VCC
*.iopin GND
XM2 net1 A VCC VCC sky130_fd_pr__pfet_01v8 L=0.15 W=2 nf=1 ad='int((nf+1)/2) * W/nf * 0.29' as='int((nf+2)/2) * W/nf * 0.29' pd='2*int((nf+1)/2) * (W/nf + 0.29)'
+ ps='2*int((nf+2)/2) * (W/nf + 0.29)' nrd='0.29 / W' nrs='0.29 / W' sa=0 sb=0 sd=0 mult=1
XM3 net1 B VCC VCC sky130_fd_pr__pfet_01v8 L=0.15 W=2 nf=1 ad='int((nf+1)/2) * W/nf * 0.29' as='int((nf+2)/2) * W/nf * 0.29' pd='2*int((nf+1)/2) * (W/nf + 0.29)'
+ ps='2*int((nf+2)/2) * (W/nf + 0.29)' nrd='0.29 / W' nrs='0.29 / W' sa=0 sb=0 sd=0 mult=1
XM5 Y net1 VCC VCC sky130_fd_pr__pfet_01v8 L=0.15 W=2 nf=1 ad='int((nf+1)/2) * W/nf * 0.29' as='int((nf+2)/2) * W/nf * 0.29' pd='2*int((nf+1)/2) * (W/nf + 0.29)'
+ ps='2*int((nf+2)/2) * (W/nf + 0.29)' nrd='0.29 / W' nrs='0.29 / W' sa=0 sb=0 sd=0 mult=1
XM1 net1 A net2 GND sky130_fd_pr__nfet_01v8 L=0.15 W=1 nf=1 ad='int((nf+1)/2) * W/nf * 0.29' as='int((nf+2)/2) * W/nf * 0.29' pd='2*int((nf+1)/2) * (W/nf + 0.29)'
+ ps='2*int((nf+2)/2) * (W/nf + 0.29)' nrd='0.29 / W' nrs='0.29 / W' sa=0 sb=0 sd=0 mult=1
XM4 net2 B GND GND sky130_fd_pr__nfet_01v8 L=0.15 W=1 nf=1 ad='int((nf+1)/2) * W/nf * 0.29' as='int((nf+2)/2) * W/nf * 0.29' pd='2*int((nf+1)/2) * (W/nf + 0.29)'
+ ps='2*int((nf+2)/2) * (W/nf + 0.29)' nrd='0.29 / W' nrs='0.29 / W' sa=0 sb=0 sd=0 mult=1
XM6 Y net1 GND GND sky130_fd_pr__nfet_01v8 L=0.15 W=1 nf=1 ad='int((nf+1)/2) * W/nf * 0.29' as='int((nf+2)/2) * W/nf * 0.29' pd='2*int((nf+1)/2) * (W/nf + 0.29)'
+ ps='2*int((nf+2)/2) * (W/nf + 0.29)' nrd='0.29 / W' nrs='0.29 / W' sa=0 sb=0 sd=0 mult=1
.ends

.GLOBAL GND
.end
